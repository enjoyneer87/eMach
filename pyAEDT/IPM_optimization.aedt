# Ansys Electronics Desktop project, version 2025.2
materials:
  M19_24G: permeability{HUnit=A_per_meter BUnit=tesla curve (0, 0) (22.28, 0.05) (25.46, 0.1) (31.83, 0.15) (47.74, 0.36) (63.66, 0.54) (79.57, 0.65) (159.15, 0.99) (318.3, 1.2) (477.46, 1.28) (636.61, 1.33) (795.77, 1.36) (1591.5, 1.44) (3183, 1.52) (4774.6, 1.58) (6366.1, 1.63) (7957.7, 1.67) (15915, 1.8) (31830, 1.9) (111407, 2) (190984, 2.1) (350138, 2.3) (509292, 2.5)} conductivity=1960000 core_loss_type="Electrical Steel" core_loss_kh=164.2 core_loss_kc=1.3 core_loss_ke=1.72 mass_density=7650
  copper_75C: permeability=0.999991 conductivity=46000000
  XG196/96: permeability{HUnit=A_per_meter BUnit=tesla curve (-690000, 0) (-663114, 0.0487979) (-635338, 0.0975957) (-606628, 0.146394) (-576936, 0.195191) (-546211, 0.243989) (-514397, 0.292787) (-481437, 0.341585) (-447266, 0.390383) (-411817, 0.439181) (-375016, 0.487979) (-333348, 0.541105) (-291679, 0.593468) (-250011, 0.64583) (-208342, 0.698192) (-166674, 0.750554) (-125005, 0.802916) (-83337, 0.855278) (-41668.5, 0.907641) (0, 0.96)} magnetic_coercivity{Magnitude=-690000A_per_meter DirComp1=1 DirComp2=0 DirComp3=0}
  vacuum: permittivity=1
  M19_24G_2DSF0.950: permeability{HUnit=A_per_meter BUnit=tesla curve (0, 0) (22.28, 0.0475014) (25.46, 0.0950016) (31.83, 0.142502) (47.74, 0.342003) (63.66, 0.513004) (79.57, 0.617505) (159.15, 0.94051) (318.3, 1.14002) (477.46, 1.21603) (636.61, 1.26354) (795.77, 1.29205) (1591.5, 1.3681) (3183, 1.4442) (4774.6, 1.5013) (6366.1, 1.5489) (7957.7, 1.587) (15915, 1.711) (31830, 1.807) (111407, 1.907) (190984, 2.007) (350138, 2.207) (509292, 2.407) (2100830, 4.407)} core_loss_type="Electrical Steel" core_loss_kh=172.842 core_loss_kc=1.36842 core_loss_ke=1.76468 mass_density=7650
  XG196/96_2DSF1.000_X: permeability=1.10716 conductivity=625000 magnetic_coercivity{Magnitude=-690000A_per_meter DirComp1=1 DirComp2=0 DirComp3=0}
  copper: permeability=0.999991 conductivity=58000000
  M19_24G_3DSF0.950: permeability{HUnit=A_per_meter BUnit=tesla curve (0, 0) (22.28, 0.05) (25.46, 0.1) (31.83, 0.15) (47.74, 0.36) (63.66, 0.54) (79.57, 0.65) (159.15, 0.99) (318.3, 1.2) (477.46, 1.28) (636.61, 1.33) (795.77, 1.36) (1591.5, 1.44) (3183, 1.52) (4774.6, 1.58) (6366.1, 1.63) (7957.7, 1.67) (15915, 1.8) (31830, 1.9) (111407, 2) (190984, 2.1) (350138, 2.3) (509292, 2.5) (2100830, 4.5)} core_loss_type="Electrical Steel" core_loss_kh=164.2 core_loss_kc=1.3 core_loss_ke=1.72 mass_density=7650 stacking_type=Lamination stacking_factor=0.95 stacking_direction=V(3)
  XG196/96_3DSF1.000_X: permeability=1.10716 magnetic_coercivity{Magnitude=-690000A_per_meter DirComp1=1 DirComp2=0 DirComp3=0}

design M2D_Transient (Maxwell 2D, Transient, XY geometry, model units mm)
notes: " This is a Maxwell 2D Transient analysis on rated conditions.

" In the Project Manager and under "2_Maxwell_2D_Transient" design:

   1.\	Choose Model/Motion Setup1.

   2.\	On the Type tab select "Rotation" as Motion Type and "Global Z" as Moving Vector, with Positive to be considered as Counterclockwise.

   3.\	On the Data tab set Initial Position as 7.5deg. This will geometrically align PhaseA with the D-axis for 0 Nm torque (or maximum back-emf) at initial time.

   4.\	On the Mechanical tab set the Angular Velocity as 3,600rpm (as rated speed).

   5.\	For Boundary Condition, due to Anti-Periodic field distribution within the symmetry, Dependent = - Independent, or Bd=-Bi, since Independent is aligned with 0X and Dependent is aligned with 0Y. To close the field inside of design space the outer boundary has zero Vector Potential.

   6.\	For Excitations all three Phases are connected to an external Circuit (shown in the Project Manager as MaxCir2).

" Postprocessing shows pre-defined reports with main motor transient characteristics. 
-
options: ComputeTransientInductance ModelDepth=65mm Notes='" This is a Maxwell 2D Transient analysis on rated conditions. / " In the Project Manager and under "2_Maxwell_2D_Transient" design: / 1.	Choose Model/Motion Setup1. / 2.	On the Type tab select "Rotation" as Motion Type and "Global Z" as Moving Vector, with Positive to be considered as Counterclockwise. / 3.	On the Data tab set Initial Position as 7.5deg. This will geometrically align PhaseA with the D-axis for 0 Nm torque (or maximum back-emf) at initial time. / 4.	On the Mechanical tab set the Angular Velocity as 3,600rpm (as rated speed). / 5.	For Boundary Condition, due to Anti-Periodic field distribution within the symmetry, Dependent = - Independent, or Bd=-Bi, since Independent is aligned with 0X and Dependent is aligned with 0Y. To close the field inside of design space the outer boundary has zero Vector Potential. / 6.	For Excitations all three Phases are connected to an external Circuit (shown in the Project Manager as MaxCir2). / " Postprocessing shows pre-defined reports with main motor transient characteristics. / -'
variables:
  fractions = 4
  din = 78mm  # tune 39mm..117mm
  gap = 0.5mm
  bridge = 2mm  # tune 1mm..3mm
  freq_e = 50Hz
  Ipeak = 200A  # tune 100A..300A
  phase_advance = 0deg  # tune -1deg..1deg
  mat_index = 0  # tune -1..1
  mat_sweep = ["XG196/96_2DSF1.000_X", "NdFe30", "NdFe35"]
geometry:
  Band [vacuum] = user_primitive(RMxprt/Band, DiaGap=(din + din - 2*gap)/2, DiaYoke=26mm, Length=0mm, SegAngle=0deg, Fractions=1, HalfAxial=0, InfoCore=0)
  Shaft [M19_24G_2DSF0.950] = user_primitive(RMxprt/Band, DiaGap=(din + din - 2*gap)/2, DiaYoke=26mm, Length=0mm, SegAngle=0deg, Fractions=1, HalfAxial=0, InfoCore=100)
  OuterRegion [vacuum] = user_primitive(RMxprt/Band, DiaGap=(din + din - 2*gap)/2, DiaYoke=120mm, Length=0mm, SegAngle=0deg, Fractions=fractions, HalfAxial=0, InfoCore=100)
  Tool = user_primitive(RMxprt/Band, DiaGap=(din + din - 2*gap)/2, DiaYoke=120mm, Length=0mm, SegAngle=0deg, Fractions=fractions, HalfAxial=0, InfoCore=1)
  Stator [M19_24G_2DSF0.950] = user_primitive(RMxprt/SlotCore, DiaGap=din, DiaYoke=120mm, Length=0mm, Skew=0deg, Slots=24, SlotType=2, Hs0=0.5mm, Hs01=0mm, Hs1=1mm, Hs2=8.2mm, Bs0=2.5mm, Bs1=5.6mm, Bs2=7.6mm, Rs=3.8mm, FilletType=0, HalfSlot=0, SegAngle=15deg, LenRegion=0mm, InfoCore=0)
  Coil_0 [copper_75C] = user_primitive(RMxprt/LapCoil, DiaGap=din, DiaYoke=120mm, Length=0mm, Skew=0deg, Slots=24, SlotType=2, Hs0=0.5mm, Hs1=1mm, Hs2=8.2mm, Bs0=2.5mm, Bs1=5.6mm, Bs2=7.6mm, Rs=3.8mm, FilletType=0, Layers=2, CoilPitch=5, EndExt=0mm, SpanExt=0mm, BendAngle=0deg, SegAngle=10deg, LenRegion=0mm, InfoCoil=2)
  Coil_1..Coil_5 [copper_75C], Coil_6..Coil_23 = Coil_0.duplicate_around_axis(axis=Z, angle=15deg, total=24)
  Coil_0.unite(Coil_6, Coil_12, Coil_18)
  Coil_1.unite(Coil_7, Coil_13, Coil_19)
  Coil_2.unite(Coil_8, Coil_14, Coil_20)
  Coil_3.unite(Coil_9, Coil_15, Coil_21)
  Coil_4.unite(Coil_10, Coil_16, Coil_22)
  Coil_5.unite(Coil_11, Coil_17, Coil_23)
  CoilRe_0 [copper_75C] = user_primitive(RMxprt/LapCoil, DiaGap=din, DiaYoke=120mm, Length=0mm, Skew=0deg, Slots=24, SlotType=2, Hs0=0.5mm, Hs1=1mm, Hs2=8.2mm, Bs0=2.5mm, Bs1=5.6mm, Bs2=7.6mm, Rs=3.8mm, FilletType=0, Layers=2, CoilPitch=5, EndExt=0mm, SpanExt=0mm, BendAngle=0deg, SegAngle=10deg, LenRegion=0mm, InfoCoil=3)
  CoilRe_0.rotate(axis=Z, angle=-75deg)
  CoilRe_1..CoilRe_5 [copper_75C], CoilRe_6..CoilRe_23 = CoilRe_0.duplicate_around_axis(axis=Z, angle=15deg, total=24)
  CoilRe_0.unite(CoilRe_6, CoilRe_12, CoilRe_18)
  CoilRe_1.unite(CoilRe_7, CoilRe_13, CoilRe_19)
  CoilRe_2.unite(CoilRe_8, CoilRe_14, CoilRe_20)
  CoilRe_3.unite(CoilRe_9, CoilRe_15, CoilRe_21)
  CoilRe_4.unite(CoilRe_10, CoilRe_16, CoilRe_22)
  CoilRe_5.unite(CoilRe_11, CoilRe_17, CoilRe_23)
  Rotor [M19_24G_2DSF0.950] = user_primitive(RMxprt/IPMCore, DiaGap=din - 2*gap, DiaYoke=26mm, Length=0mm, Poles=4, PoleType=5, D1=din - 2*gap - 2*bridge, O1=1mm, O2=3mm, B1=4mm, Rib=3mm, HRib=3mm, DminMag=0mm, ThickMag=5mm, WidthMag=44.548767mm, LenRegion=0mm, InfoCore=0)
  Rotor.rotate(axis=Z, angle=45deg)
  coordinate_system relativeCS1_0 = origin=(0, 0, 0) x=(0.91405257, 0.40559573, 0) y=(-0.40559573, 0.91405257, 0)
  Mag1_0 [mat_sweep[mat_index], oriented by relativeCS1_0] = user_primitive(RMxprt/IPMCore, DiaGap=din - 2*gap, DiaYoke=26mm, Length=0mm, Poles=4, PoleType=5, D1=din - 2*gap - 2*bridge, O1=1mm, O2=3mm, B1=4mm, Rib=3mm, HRib=3mm, DminMag=0mm, ThickMag=5mm, WidthMag=44.548767mm, LenRegion=0mm, InfoCore=-1)
  Mag1_0.rotate(axis=Z, angle=45deg)
  Mag1_1, Mag1_2, Mag1_3 = Mag1_0.duplicate_around_axis(axis=Z, angle=90deg, total=4)
  Mag1_0.unite(Mag1_1, Mag1_2, Mag1_3)
  coordinate_system relativeCS2_0 = origin=(0, 0, 0) x=(0.40559573, 0.91405257, 0) y=(-0.91405257, 0.40559573, 0)
  Mag2_0 [mat_sweep[mat_index], oriented by relativeCS2_0] = user_primitive(RMxprt/IPMCore, DiaGap=din - 2*gap, DiaYoke=26mm, Length=0mm, Poles=4, PoleType=5, D1=din - 2*gap - 2*bridge, O1=1mm, O2=3mm, B1=4mm, Rib=3mm, HRib=3mm, DminMag=0mm, ThickMag=5mm, WidthMag=44.548767mm, LenRegion=0mm, InfoCore=-2)
  Mag2_0.rotate(axis=Z, angle=45deg)
  Mag2_1, Mag2_2, Mag2_3 = Mag2_0.duplicate_around_axis(axis=Z, angle=90deg, total=4)
  Mag2_0.unite(Mag2_1, Mag2_2, Mag2_3)
  Duct1 = user_primitive(RMxprt/IPMCore, DiaGap=din - 2*gap, DiaYoke=26mm, Length=0mm, Poles=4, PoleType=5, D1=din - 2*gap - 2*bridge, O1=1mm, O2=10.499122mm, B1=4mm, Rib=16.473769mm, HRib=0mm, DminMag=0mm, ThickMag=5mm, WidthMag=30.451233mm, LenRegion=0mm, InfoCore=2)
  Duct1.rotate(axis=Z, angle=45deg)
  Rotor.subtract(Duct1)
  Mag3_0 [mat_sweep[mat_index], oriented by relativeCS1_0] = user_primitive(RMxprt/IPMCore, DiaGap=din - 2*gap, DiaYoke=26mm, Length=0mm, Poles=4, PoleType=5, D1=din - 2*gap - 2*bridge, O1=1mm, O2=10.499122mm, B1=4mm, Rib=16.473769mm, HRib=0mm, DminMag=0mm, ThickMag=5mm, WidthMag=30.451233mm, LenRegion=0mm, InfoCore=-1)
  Mag3_0.rotate(axis=Z, angle=45deg)
  Mag3_1, Mag3_2, Mag3_3 = Mag3_0.duplicate_around_axis(axis=Z, angle=90deg, total=4)
  Mag3_0.unite(Mag3_1, Mag3_2, Mag3_3)
  Mag4_0 [mat_sweep[mat_index], oriented by relativeCS2_0] = user_primitive(RMxprt/IPMCore, DiaGap=din - 2*gap, DiaYoke=26mm, Length=0mm, Poles=4, PoleType=5, D1=din - 2*gap - 2*bridge, O1=1mm, O2=10.499122mm, B1=4mm, Rib=16.473769mm, HRib=0mm, DminMag=0mm, ThickMag=5mm, WidthMag=30.451233mm, LenRegion=0mm, InfoCore=-2)
  Mag4_0.rotate(axis=Z, angle=45deg)
  Mag4_1, Mag4_2, Mag4_3 = Mag4_0.duplicate_around_axis(axis=Z, angle=90deg, total=4)
  Mag4_0.unite(Mag4_1, Mag4_2, Mag4_3)
  InnerRegion [vacuum] = user_primitive(RMxprt/IPMCore, DiaGap=din - 2*gap, DiaYoke=26mm, Length=0mm, Poles=4, PoleType=5, D1=din - 2*gap - 2*bridge, O1=1mm, O2=10.499122mm, B1=4mm, Rib=16.473769mm, HRib=0mm, DminMag=0mm, ThickMag=5mm, WidthMag=30.451233mm, LenRegion=0mm, InfoCore=100)
  InnerRegion.rotate(axis=Z, angle=45deg)
  Tool_1 = Tool.copy()
  Band.subtract(Tool_1)
  Tool_2 = Tool.copy()
  InnerRegion.subtract(Tool_2)
  Tool_3 = Tool.copy()
  Shaft.subtract(Tool_3)
  Tool_4 = Tool.copy()
  Stator.subtract(Tool_4)
  Tool_5 = Tool.copy()
  Coil_0.subtract(Tool_5)
  Tool_6 = Tool.copy()
  Coil_1.subtract(Tool_6)
  Tool_7 = Tool.copy()
  Coil_2.subtract(Tool_7)
  Tool_8 = Tool.copy()
  Coil_3.subtract(Tool_8)
  Tool_9 = Tool.copy()
  Coil_4.subtract(Tool_9)
  Tool_10 = Tool.copy()
  Coil_5.subtract(Tool_10)
  Tool_11 = Tool.copy()
  CoilRe_0.subtract(Tool_11)
  Tool_12 = Tool.copy()
  CoilRe_1.subtract(Tool_12)
  Tool_13 = Tool.copy()
  CoilRe_2.subtract(Tool_13)
  Tool_14 = Tool.copy()
  CoilRe_3.subtract(Tool_14)
  Tool_15 = Tool.copy()
  CoilRe_4.subtract(Tool_15)
  Tool_16 = Tool.copy()
  CoilRe_5.subtract(Tool_16)
  Tool_17 = Tool.copy()
  Rotor.subtract(Tool_17)
  Tool_18 = Tool.copy()
  Mag1_0.subtract(Tool_18)
  Tool_19 = Tool.copy()
  Mag2_0.subtract(Tool_19)
  Tool_20 = Tool.copy()
  Mag3_0.subtract(Tool_20)
  Mag4_0.subtract(Tool)
motion:
  MotionSetup1: Band Move_Type=Rotate Coordinate_System=Global Axis=Z Is_Positive=true InitPos=7.5deg Angular_Velocity=1500rpm Objects=Band
  Moving1: Moving Objects=[Shaft, Rotor, Mag1_0, Mag2_0, Mag3_0, Mag4_0, InnerRegion]
boundaries and excitations:
  VectorPotential1: Vector Potential Edges=OuterRegion.edge(at (42.4264, 42.4264, 0)) Value=0
  Independent1: Independent Edges=OuterRegion.edge(at (30, 0, 0))
  Dependent1: Dependent Edges=OuterRegion.edge(at (0, 30, 0)) ReverseU Independent=Independent1 SameAsMaster=false
  PhA_0: Coil Objects=Coil_0 Conductor_number=26 Winding=PhaseA PolarityType=Positive
  PhARe_0: Coil Objects=CoilRe_5 Conductor_number=26 Winding=PhaseA PolarityType=Negative
  PhA_1: Coil Objects=Coil_1 Conductor_number=26 Winding=PhaseA PolarityType=Positive
  PhCRe_2: Coil Objects=Coil_2 Conductor_number=26 Winding=PhaseC PolarityType=Negative
  PhCRe_3: Coil Objects=Coil_3 Conductor_number=26 Winding=PhaseC PolarityType=Negative
  PhB_4: Coil Objects=Coil_4 Conductor_number=26 Winding=PhaseB PolarityType=Positive
  PhB_5: Coil Objects=Coil_5 Conductor_number=26 Winding=PhaseB PolarityType=Positive
  PhA_19: Coil Objects=CoilRe_0 Conductor_number=26 Winding=PhaseA PolarityType=Positive
  PhCRe_20: Coil Objects=CoilRe_1 Conductor_number=26 Winding=PhaseC PolarityType=Negative
  PhCRe_21: Coil Objects=CoilRe_2 Conductor_number=26 Winding=PhaseC PolarityType=Negative
  PhB_22: Coil Objects=CoilRe_3 Conductor_number=26 Winding=PhaseB PolarityType=Positive
  PhB_23: Coil Objects=CoilRe_4 Conductor_number=26 Winding=PhaseB PolarityType=Positive
  PhaseA: Winding Group Type=Current IsSolid=false Current=Ipeak*sin(2*50*pi*time+phase_advance) ParallelBranchesNum=1
  PhaseB: Winding Group Type=Current IsSolid=false Current=Ipeak*sin(2*50*pi*time-2*pi/3+phase_advance) ParallelBranchesNum=1
  PhaseC: Winding Group Type=Current IsSolid=false Current=Ipeak*sin(2*50*pi*time-4*pi/3+phase_advance) ParallelBranchesNum=1
  eddy effects on: Mag1_0, Mag2_0, Mag3_0, Mag4_0
  core loss on: Stator, Rotor
  external circuit: "* Design: MaxCir2"
mesh:
  SurfApprox_Mag: SurfApproxBased Objects=[Mag1_0, Mag2_0, Mag3_0, Mag4_0] CurvedSurfaceApproxChoice=ManualSettings SurfDev=0.037mm NormalDev=15deg
  SurfApprox_Main: SurfApproxBased Objects=[Stator, Rotor, Band, OuterRegion, InnerRegion, Shaft] CurvedSurfaceApproxChoice=ManualSettings SurfDev=0.06mm NormalDev=15deg
  CylindricalGap1: CylindricalGap Objects=Band BandMappingAngle=3deg Objects=Band
setups:
  Setup1: Transient NonlinearSolverResidual=0.0001 StopTime=1/freq_e TimeStep=1/freq_e/360 InitialTimeStep=0.002s MinTimeStep=0.001s MaxTimeStep=0.003s TimeStepErrTolerance=0.0001
optimetrics:
  Parametric_9HCX0H: Parametric InterpolationPoints=0 Sim._Setups=[Setup1]
    sweep bridge: 0.5mm
    sweep din: LIN 78mm 80mm 10mm
    sweep phase_advance: 45deg
    sweep Ipeak: 200A
    sweep mat_index: LIN 0 2 1
output variables:
  pos = (Moving1.Position -7.5 * PI/180) * 2 + PI
  cos0 = cos(pos)
  cos1 = cos(pos-2*PI/3)
  cos2 = cos(pos-4*PI/3)
  sin0 = sin(pos)
  sin1 = sin(pos-2*PI/3)
  sin2 = sin(pos-4*PI/3)
  Lad = L(PhaseA,PhaseA)*cos0 + L(PhaseA,PhaseB)*cos1 + L(PhaseA,PhaseC)*cos2
  Laq = L(PhaseA,PhaseA)*sin0 + L(PhaseA,PhaseB)*sin1 + L(PhaseA,PhaseC)*sin2
  Lbd = L(PhaseB,PhaseA)*cos0 + L(PhaseB,PhaseB)*cos1 + L(PhaseB,PhaseC)*cos2
  Lbq = L(PhaseB,PhaseA)*sin0 + L(PhaseB,PhaseB)*sin1 + L(PhaseB,PhaseC)*sin2
  Lcd = L(PhaseC,PhaseA)*cos0 + L(PhaseC,PhaseB)*cos1 + L(PhaseC,PhaseC)*cos2
  Lcq = L(PhaseC,PhaseA)*sin0 + L(PhaseC,PhaseB)*sin1 + L(PhaseC,PhaseC)*sin2
  L_d = (Lad*cos0 + Lbd*cos1 + Lcd*cos2) * 2/3
  L_q = (Laq*sin0 + Lbq*sin1 + Lcq*sin2) * 2/3
  Flux_d = (FluxLinkage(PhaseA)*cos0+FluxLinkage(PhaseB)*cos1+FluxLinkage(PhaseC)*cos2)*2/3
  Flux_q = (FluxLinkage(PhaseA)*sin0+FluxLinkage(PhaseB)*sin1+FluxLinkage(PhaseC)*sin2)*2/3
  I_d = (Current(PhaseA)*cos0 + Current(PhaseB)*cos1 + Current(PhaseC)*cos2)*2/3
  I_q = (Current(PhaseA)*sin0 + Current(PhaseB)*sin1 + Current(PhaseC)*sin2)*2/3
  Irms = sqrt(I_d^2+I_q^2)/sqrt(2)
  Pcu = 3*Irms^2*0
